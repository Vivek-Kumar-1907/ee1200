Band pass filter design (resonant circuit)

*V1 vin 0 PULSE(0, 5, 0, 1n, 1n, 0.166m, 0.333m)
*V1 vin 0 SIN(0, 5, 15k, 0, 0, 0)
V1 vin 0 AC 5

C1 1 vin 560p
L1 1 2 201m
R1 2 0 100

.control
    *tran 15u 1 0.9996
    ac dec 100 10 10e6
    plot db(v(2))
.endc
