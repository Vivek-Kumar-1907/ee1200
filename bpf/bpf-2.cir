Band pass filter design (hpf - lpf - hpf - lpf)

*V1 vin 0 PULSE(0, 5, 0, 1n, 1n, 0.166m, 0.333m)
V1 vin 0 AC 5

R1 1 vin 48k
C1 1 0 560p
C2 1 2 560p
R2 2 0 7.5k

*R3 3 2 24k
*C3 3 0 560p
*C4 3 4 560p
*R4 4 0 15k

*R5 5 4 24k
*C5 5 0 560p
*C6 5 6 560p
*R6 6 0 15k
*
*R7 7 6 24k
*C7 7 0 560p
*C8 7 8 560p
*R8 8 0 15k
*
*R9 9 8 24k
*C9 9 0 560p
*C10 9 10 560p
*R10 10 0 15k
*
*R11 11 10 24k
*C11 11 0 560p
*C12 11 12 560p
*R12 12 0 15k
*
*R13 13 12 24k
*C13 13 0 560p
*C14 13 14 560p
*R14 14 0 15k
*
*R15 15 14 24k
*C15 15 0 560p
*C16 15 16 560p
*R16 16 0 15k
*
.control
    ac dec 100 1000 100000
    plot db(v(2))
.endc
