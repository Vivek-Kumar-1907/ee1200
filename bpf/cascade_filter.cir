* Automatic N-Stage Filter Generator (N=100)
* Generated by Python

* --- Single Stage Subcircuit ---
.subckt bp_stage in out gnd
  C1 in mid  560p
  R1 mid gnd 18.94k
  R2 mid out 18.94k
  C2 out gnd 560p
.ends bp_stage

* --- Main Circuit ---
Vin source 0 AC 1
* Cascading 100 stages automatically:
X1 source n1 0 bp_stage
X2 n1 n2 0 bp_stage
X3 n2 n3 0 bp_stage
X4 n3 n4 0 bp_stage
X5 n4 n5 0 bp_stage
X6 n5 n6 0 bp_stage
X7 n6 n7 0 bp_stage
X8 n7 n8 0 bp_stage
X9 n8 n9 0 bp_stage
X10 n9 n10 0 bp_stage
X11 n10 n11 0 bp_stage
X12 n11 n12 0 bp_stage
X13 n12 n13 0 bp_stage
X14 n13 n14 0 bp_stage
X15 n14 n15 0 bp_stage
X16 n15 n16 0 bp_stage
X17 n16 n17 0 bp_stage
X18 n17 n18 0 bp_stage
X19 n18 n19 0 bp_stage
X20 n19 n20 0 bp_stage
X21 n20 n21 0 bp_stage
X22 n21 n22 0 bp_stage
X23 n22 n23 0 bp_stage
X24 n23 n24 0 bp_stage
X25 n24 n25 0 bp_stage
X26 n25 n26 0 bp_stage
X27 n26 n27 0 bp_stage
X28 n27 n28 0 bp_stage
X29 n28 n29 0 bp_stage
X30 n29 n30 0 bp_stage
X31 n30 n31 0 bp_stage
X32 n31 n32 0 bp_stage
X33 n32 n33 0 bp_stage
X34 n33 n34 0 bp_stage
X35 n34 n35 0 bp_stage
X36 n35 n36 0 bp_stage
X37 n36 n37 0 bp_stage
X38 n37 n38 0 bp_stage
X39 n38 n39 0 bp_stage
X40 n39 n40 0 bp_stage
X41 n40 n41 0 bp_stage
X42 n41 n42 0 bp_stage
X43 n42 n43 0 bp_stage
X44 n43 n44 0 bp_stage
X45 n44 n45 0 bp_stage
X46 n45 n46 0 bp_stage
X47 n46 n47 0 bp_stage
X48 n47 n48 0 bp_stage
X49 n48 n49 0 bp_stage
X50 n49 n50 0 bp_stage
X51 n50 n51 0 bp_stage
X52 n51 n52 0 bp_stage
X53 n52 n53 0 bp_stage
X54 n53 n54 0 bp_stage
X55 n54 n55 0 bp_stage
X56 n55 n56 0 bp_stage
X57 n56 n57 0 bp_stage
X58 n57 n58 0 bp_stage
X59 n58 n59 0 bp_stage
X60 n59 n60 0 bp_stage
X61 n60 n61 0 bp_stage
X62 n61 n62 0 bp_stage
X63 n62 n63 0 bp_stage
X64 n63 n64 0 bp_stage
X65 n64 n65 0 bp_stage
X66 n65 n66 0 bp_stage
X67 n66 n67 0 bp_stage
X68 n67 n68 0 bp_stage
X69 n68 n69 0 bp_stage
X70 n69 n70 0 bp_stage
X71 n70 n71 0 bp_stage
X72 n71 n72 0 bp_stage
X73 n72 n73 0 bp_stage
X74 n73 n74 0 bp_stage
X75 n74 n75 0 bp_stage
X76 n75 n76 0 bp_stage
X77 n76 n77 0 bp_stage
X78 n77 n78 0 bp_stage
X79 n78 n79 0 bp_stage
X80 n79 n80 0 bp_stage
X81 n80 n81 0 bp_stage
X82 n81 n82 0 bp_stage
X83 n82 n83 0 bp_stage
X84 n83 n84 0 bp_stage
X85 n84 n85 0 bp_stage
X86 n85 n86 0 bp_stage
X87 n86 n87 0 bp_stage
X88 n87 n88 0 bp_stage
X89 n88 n89 0 bp_stage
X90 n89 n90 0 bp_stage
X91 n90 n91 0 bp_stage
X92 n91 n92 0 bp_stage
X93 n92 n93 0 bp_stage
X94 n93 n94 0 bp_stage
X95 n94 n95 0 bp_stage
X96 n95 n96 0 bp_stage
X97 n96 n97 0 bp_stage
X98 n97 n98 0 bp_stage
X99 n98 n99 0 bp_stage
X100 n99 v_out 0 bp_stage

* --- Simulation Control ---
.control
  ac dec 20 1000 100000
  plot db(v(source)) db(v(v_out)) title 'Frequency Response'
.endc
.end
