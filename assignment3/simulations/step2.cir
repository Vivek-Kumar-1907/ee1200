Step Signal (discharging)

Vsource 1 0 PULSE(0 5 0 1n 1n 10.2m 15m)
R1 2 0 820
C1 1 2 1u

.tran 0.1ms 12ms 10ms

.control
    run
    display
    gnuplot step2 v(1) v(2)
.endc

.end
