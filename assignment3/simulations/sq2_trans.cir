Square Wave 820us (Transient)

Vsource 2 0 PULSE(0 5 0 1n 1n 410u 820u)
R1 1 0 820
C1 2 1 1u

* Simulate first 2.5ms (approx 3 cycles)
.tran 2u 2.5ms

.control
    run
    wrdata sq2_trans.txt v(1) v(2)
.endc

.end
