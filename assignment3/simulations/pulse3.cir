16ms Pulse Signal

Vsource 2 0 PULSE(0 5 0.1m 1n 1n 16m 50m)
R1 1 0 820
C1 2 1 1u

.tran 10u 20m 0

.control
    run
    wrdata pulse3_data.txt v(1) v(2)
.endc

.end
