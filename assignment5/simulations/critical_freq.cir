Frequency Response - Critically Damped

Vsource 3 0 AC 1
C1 1 0 561p
L1 3 2 50m
R1 2 1 18.88k

.control
    ac dec 1000 1 10e4
    gnuplot critical_freq db(v(1))
.endc

.end
