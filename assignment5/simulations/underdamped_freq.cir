Frequency Response - Underdamped

Vsource 3 0 AC 1
C1 1 0 561p
L1 3 2 50m
R1 2 1 2.2k

.control
    ac dec 1000 1 1e5
    gnuplot underdamped_freq db(v(1))
.endc

.end
