Square Wave 82ms (Transient)

Vsource 2 0 PULSE(0 5 0 1n 1n 41m 82m)
R1 2 1 820
C1 1 0 1u

* Simulate first 165ms (2 cycles)
.tran 100u 165ms

.control
    run
    wrdata sq3_trans.txt v(1) v(2)
.endc

.end
